* AD8666 SPICE Macro-model
* 0.9Beta Rev (10/14/2013)
* Generic Desc: 5/16V, CMOS, OP, Low Noise, S SPLY, 1X
* Developed by: RM
* Revsion history: 02/06/2015 (KF) - fixed output swing
* Revision History: 08/10/2012 - Updated to new header style
* 0.0 (05/2008)

* Copyright 2006, 2012 by Analog Devices
*
* Refer to http://www.analog.com/Analog_Root/static/techSupport/designTools/spiceModels/license/spice_general.html for License Statement.  Use of this model
* indicates your acceptance of the terms and provisions in the License Statement.
*
* BEGIN Notes:
*
* Not Modeled:
*
* Parameters modeled include:
*
* END Notes
*
* Node Assignments
*                       noninverting input
*                       |   inverting input
*                       |   |    positive supply
*                       |   |    |   negative supply
*                       |   |    |   |   output
*                       |   |    |   |   |
*                       |   |    |   |   |
.SUBCKT AD8666-2          1   2   99  50  45
*
*
* INPUT STAGE
*
M1  14  7  8  8 PIX L=1E-6 W=3.02E-03
M2  16  2  8  8 PIX L=1E-6 W=3.02E-03
RC5 14 50 8.00E+02
RC6 16 50 8.00E+02
C1  14 16 1.00E-11
I1  99  8 5.00E-04
V1  99  9 2.071E+00
D1   8  9 DX
EOS  7  1 POLY(4) (22,98) (73,98) (81,98) (70,98) 6.00E-04 1 1 1 1
IOS  1  2 1.00E-13
*
*
* CMRR=110dB, POLE AT 250 Hz
*
E1  21 98 POLY(2) (1,98) (2,98) 0 1.26E-01 1.26E-01
R10 21 22 6.37E+02
R20 22 98 7.96E-03
C10 21 22 1.00E-06
*
* PSRR=115dB, POLE AT 20 Hz
*
EPSY 72 98 POLY(1) (99,50) -2.13E+01 1.33E+00
CPS3 72 73 1.00E-06
RPS3 72 73 7.96E+03
RPS4 73 98 1.06E-02
*
* VOLTAGE NOISE REFERENCE OF 10nV/rt(Hz)
*
VN1 80 98 0
RN1 80 98 16.45E-3
HN  81 98 VN1 9.89E+00
RN2 81 98 1
*
* FLICKER NOISE CORNER = 300 Hz
*
D5  69 98 DNOISE
VSN 69 98 DC 0.6551
H1  70 98 POLY(1) VSN 1.00E-03 1.00E+00
RN  70 98 1
*
* INTERNAL VOLTAGE REFERENCE
*
EREF 98  0 POLY(2) (99,0) (50,0) 0 0.5 0.5
GSY  99 50 POLY(1) (99,50) -1.34E-05 1.10E-05
EVP  97 98 POLY(1) (99,50) 0 0.5
EVN  51 98 POLY(1) (50,99) 0 0.5
*
* GAIN STAGE
*
G1 98 30 POLY(1) (14,16)  0 4.83E-04
R1 30 98 1.00E+06
RZ 30 31 2.05E+02
CF 45 31 5.52E-11
*V3 32 30 2.89E+00
V3 32 30 2.59E+00
V4 30 33 -0.16E+00
*V4 30 33 -0.86E+00
D3 32 97 DX
D4 51 33 DX
*
* OUTPUT STAGE
*
M5  45 46 99 99 POX L=1E-6 W=2.23E-04
*M5  45 46 99 99 POX L=1E-6 W=7.23E-04
M6  45 47 50 50 NOX L=1E-6 W=7.38E-04
EG1 99 46 POLY(1) (98,30) 6.639E-01 1
*EG1 99 46 POLY(1) (98,30) 20.639E-01 1
*EG2 47 50 POLY(1) (30,98) 6.77E-01 1
EG2 47 50 POLY(1) (30,98) 6.77E-01 1
*
* MODELS
*
.MODEL POX PMOS (LEVEL=2,KP=1.00E-05,VTO=-0.328,LAMBDA=0.01,RD=0)
.MODEL NOX NMOS (LEVEL=2,KP=1.00E-05,VTO=+0.328,LAMBDA=0.01,RD=0)
.MODEL PIX PMOS (LEVEL=2,KP=1.00E-05,VTO=-5.00E-01,LAMBDA=0.01)
.MODEL DX D(IS=1E-14,RS=5)
.MODEL DNOISE D(IS=1E-14,RS=0,KF=3.00E-11)
*
*
.ENDS AD8666-2
*
*$
